memory-map:
  bus: wb-32
  word-endian: little
  name: top
  description: Poly94 control/status registers

  x-hdl:
    name-suffix: _csr

  children:
  - submap:
      name: SYS
      address: 0x0000
      description: An included submap
      filename: sys.cheby
      include: True
  - submap:
      name: UART
      address: 0x0010
      description: An included submap
      filename: uart.cheby
      include: True
  - submap:
      name: VIDEO
      address: 0x0020
      description: An included submap
      filename: video.cheby
      include: True
